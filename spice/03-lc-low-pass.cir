* Derived from 03-lc-low-pass.asc
V1 VIN 0 AC 1
L1 VOUT VIN 1m
C1 VOUT 0 1u
RLOAD VOUT 0 100
.ac dec 200 10 1Meg
.end
