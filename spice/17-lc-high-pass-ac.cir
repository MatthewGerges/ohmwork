* Derived from 17-lc-high-pass-ac.asc
V1 VIN 0 AC 1
C1 VOUT VIN 1u
L1 VOUT 0 1m
RLOAD VOUT 0 100
.ac dec 200 10 1Meg
.end
