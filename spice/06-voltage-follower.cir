* Derived from 06-voltage-follower.asc
XU1 VIN VOUT VP VN VOUT level2
VIN_SOURCE VIN 0 SINE(0 2 1k)
RLOAD VOUT 0 10k
VCC VP 0 12
VEE VN 0 -12
.include "/Users/matthewgerges/Library/Application Support/LTspice/lib/sub/UniversalOpAmp2.lib"
.tran 0 5m 0 1u
.end
